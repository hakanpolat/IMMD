# Ansys Electronics Desktop project, version 2017.0
project variables:
  $hande = 265mm
  $mag_emb = 0.82
  $mag_thick = 4.3mm
  $bs0 = 5mm
  $turns = 60cel
  $length = 180mm
  $conductor = 60
materials:
  M19-24G: permeability{BType=normal HUnit=A_per_meter BUnit=tesla curve (0, 0) (22.28, 0.05) (25.46, 0.1) (31.83, 0.15) (47.74, 0.36) (63.66, 0.54) (79.57, 0.65) (159.15, 0.99) (318.3, 1.2) (477.46, 1.28) (636.61, 1.33) (795.77, 1.36) (1591.5, 1.44) (3183, 1.52) (4774.6, 1.58) (6366.1, 1.63) (7957.7, 1.67) (15915, 1.8) (31830, 1.9) (111407, 2) (190984, 2.1) (350138, 2.3) (509292, 2.5)} core_loss_type="Electrical Steel" core_loss_kc=4.3255556 mass_density=7650
  XG196/96: permeability{BType=normal HUnit=A_per_meter BUnit=tesla curve (-690000, 0) (-663113.52, 0.048797862) (-635337.77, 0.097595724) (-606627.88, 0.14639359) (-576935.93, 0.19519145) (-546210.65, 0.24398931) (-514397.15, 0.29278717) (-481436.56, 0.34158503) (-447265.71, 0.39038289) (-411816.7, 0.43918076) (-375016.43, 0.48797862) (-333347.94, 0.54110533) (-291679.45, 0.5934675) (-250010.95, 0.64582967) (-208342.46, 0.69819184) (-166673.97, 0.75055402) (-125005.48, 0.80291619) (-83336.985, 0.85527836) (-41668.492, 0.90764053) (0, 0.96)}
  NdFe35: permittivity=1 permeability=1.0997785 conductivity=625000 magnetic_coercivity{Magnitude=-890000A_per_meter DirComp1=1 DirComp2=0 DirComp3=0} lande_g_factor=2 mass_density=7400
  vacuum: permittivity=1
  steel_1010: permittivity=1 permeability{BType=normal HUnit=A_per_meter BUnit=tesla curve (0, 0) (238.7, 0.2003) (318.3, 0.3204) (358.1, 0.40045) (437.7, 0.50055) (477.5, 0.5606) (636.6, 0.7908) (795.8, 0.931) (1114.1, 1.1014) (1273.2, 1.2016) (1591.5, 1.302) (2228.2, 1.4028) (3183.1, 1.524) (4774.6, 1.626) (6366.2, 1.698) (7957.7, 1.73) (15915.5, 1.87) (31831, 1.99) (47746.5, 2.04) (63662, 2.07) (79577.5, 2.095) (159155, 2.2) (318310, 2.4)} conductivity=2000000 lande_g_factor=2 mass_density=7872
  M19-24G_2DSF0.950: permeability{BType=normal HUnit=A_per_meter BUnit=tesla curve (0, 0) (22.28, 0.0475014) (25.46, 0.0950016) (31.83, 0.142502) (47.74, 0.342003) (63.66, 0.513004) (79.57, 0.617505) (159.15, 0.94051) (318.3, 1.14002) (477.46, 1.21603) (636.61, 1.26354) (795.77, 1.29205) (1591.5, 1.3681) (3183, 1.4442) (4774.6, 1.5013) (6366.1, 1.5489) (7957.7, 1.587) (15915, 1.711) (31830, 1.807) (111407, 1.907) (190984, 2.007) (350138, 2.207) (509292, 2.407) (2100830, 4.407)} core_loss_type="Electrical Steel" core_loss_kc=4.55322 mass_density=7267.5
  NdFe35_2DSF1.000_N: CoordinateSystemType=Cylindrical permeability=1.09978 conductivity=625000 magnetic_coercivity{Magnitude=-890000A_per_meter DirComp1=1 DirComp2=0 DirComp3=0} mass_density=7400
  NdFe35_2DSF1.000_S: CoordinateSystemType=Cylindrical permeability=1.09978 conductivity=625000 magnetic_coercivity{Magnitude=-890000A_per_meter DirComp1=-1 DirComp2=0 DirComp3=0} mass_density=7400
  copper: permeability=0.999991 conductivity=58000000 mass_density=8933
  steel_1010_2DSF0.950: permeability{BType=normal HUnit=A_per_meter BUnit=tesla curve (0, 0) (238.7, 0.1903) (318.3, 0.3044) (358.1, 0.38045) (437.7, 0.47555) (477.5, 0.5326) (636.6, 0.7513) (795.8, 0.8845) (1114.1, 1.0464) (1273.2, 1.1416) (1591.5, 1.237) (2228.2, 1.3328) (3183.1, 1.448) (4774.6, 1.545) (6366.2, 1.6135) (7957.7, 1.644) (15915.5, 1.7775) (31831, 1.8925) (47746.5, 1.941) (63662, 1.9705) (79577.5, 1.99525) (159155, 2.1) (318310, 2.3) (1909860, 4.3)} conductivity=2000000 mass_density=7478.4
  NdFe40: permittivity=1 permeability=1.107877 conductivity=625000 magnetic_coercivity{Magnitude=-923000A_per_meter DirComp1=1 DirComp2=0 DirComp3=0} lande_g_factor=2 mass_density=7400
  NdFe45: permittivity=1 permeability=1.2491812 conductivity=625000 magnetic_coercivity{Magnitude=-860000A_per_meter DirComp1=1 DirComp2=0 DirComp3=0} lande_g_factor=2 mass_density=7400
  NdFe45_2DSF1.000_N: CoordinateSystemType=Cylindrical permeability=1.24918 conductivity=625000 magnetic_coercivity{Magnitude=-860000A_per_meter DirComp1=1 DirComp2=0 DirComp3=0} mass_density=7400
  NdFe45_2DSF1.000_S: CoordinateSystemType=Cylindrical permeability=1.24918 conductivity=625000 magnetic_coercivity{Magnitude=-860000A_per_meter DirComp1=-1 DirComp2=0 DirComp3=0} mass_density=7400
  NdFe48H: permittivity=1 permeability=1.0940918 conductivity=625000 magnetic_coercivity{Magnitude=-1011000A_per_meter DirComp1=1 DirComp2=0 DirComp3=0} lande_g_factor=2 mass_density=7400
  NdFe48H_2DSF1.000_N: CoordinateSystemType=Cylindrical permeability=1.09409 conductivity=625000 magnetic_coercivity{Magnitude=-1011000A_per_meter DirComp1=1 DirComp2=0 DirComp3=0} mass_density=7400
  NdFe48H_2DSF1.000_S: CoordinateSystemType=Cylindrical permeability=1.09409 conductivity=625000 magnetic_coercivity{Magnitude=-1011000A_per_meter DirComp1=-1 DirComp2=0 DirComp3=0} mass_density=7400
  iron: permeability=4000 conductivity=10300000 mass_density=7870
  iron_2DSF0.950: permeability=3800.05
  NdFe45H: permittivity=1 permeability=1.0557011 conductivity=625000 magnetic_coercivity{Magnitude=-995000A_per_meter DirComp1=1 DirComp2=0 DirComp3=0} lande_g_factor=2 mass_density=7400
  m250-35a: core_loss_curve{50Hz (0, 0) (0.1, 0.02) (0.2, 0.06) (0.3, 0.13) (0.4, 0.21) (0.5, 0.31) (0.6, 0.41) (0.7, 0.52) (0.8, 0.66) (0.9, 0.81) (1, 0.98) (1.1, 1.15) (1.2, 1.37) (1.3, 1.65) (1.4, 2) (1.5, 2.35) (1.6, 2.65) (1.7, 2.87) (1.8, 3.06)} core_loss_curve{100Hz (0, 0) (0.1, 0.04) (0.2, 0.14) (0.3, 0.31) (0.4, 0.51) (0.5, 0.75) (0.6, 1.01) (0.7, 1.31) (0.8, 1.64) (0.9, 2) (1, 2.41) (1.1, 2.87) (1.2, 3.4) (1.3, 4.03) (1.4, 4.83) (1.5, 5.72)} core_loss_curve{200Hz (0, 0) (0.1, 0.08) (0.2, 0.33) (0.3, 0.73) (0.4, 1.23) (0.5, 1.82) (0.6, 2.49) (0.7, 3.26) (0.8, 4.12) (0.9, 5.07) (1, 6.14) (1.1, 7.33) (1.2, 8.69) (1.3, 10.3) (1.4, 12.4) (1.5, 14.7)} core_loss_curve{400Hz (0, 0) (0.1, 0.21) (0.2, 0.9) (0.3, 1.93) (0.4, 3.24) (0.5, 4.81) (0.6, 6.69) (0.7, 8.82) (0.8, 11.2) (0.9, 14) (1, 17.1) (1.1, 20.6) (1.2, 24.6) (1.3, 29.2) (1.4, 35.1) (1.5, 41.6)} core_loss_curve{1000Hz (0, 0) (0.1, 0.98) (0.2, 3.65) (0.3, 7.58) (0.4, 12.7) (0.5, 18.8) (0.6, 26.3) (0.7, 35.2) (0.8, 45.7) (0.9, 58.1) (1, 72.6) (1.1, 89.6)} core_loss_curve{2500Hz (0, 0) (0.1, 4.09) (0.2, 14.8) (0.3, 30.6) (0.4, 51.7) (0.5, 78.8) (0.6, 113) (0.7, 155) (0.8, 208) (0.9, 273) (1, 352)} permittivity=1 permeability{BType=normal HUnit=A_per_meter BUnit=tesla curve (0, 0) (26.8, 0.1) (35.7, 0.2) (41.8, 0.3) (47.5, 0.4) (53.4, 0.5) (60, 0.6) (67.9, 0.7) (77.5, 0.8) (90, 0.9) (107, 1) (133, 1.1) (179, 1.2) (284, 1.3) (642, 1.4) (1810, 1.5) (4030, 1.6) (7290, 1.7) (11700, 1.8)} conductivity=2000000 lande_g_factor=2 core_loss_type="Electrical Steel" core_loss_kh=215.77775 core_loss_kc=0.33909564 mass_density=7872
  NdFe45H_2DSF1.000_N: CoordinateSystemType=Cylindrical permeability=1.0557 conductivity=625000 magnetic_coercivity{Magnitude=-995000A_per_meter DirComp1=1 DirComp2=0 DirComp3=0} mass_density=7400
  NdFe45H_2DSF1.000_S: CoordinateSystemType=Cylindrical permeability=1.0557 conductivity=625000 magnetic_coercivity{Magnitude=-995000A_per_meter DirComp1=-1 DirComp2=0 DirComp3=0} mass_density=7400
  m250-35a_2DSF0.920: permeability{BType=normal HUnit=A_per_meter BUnit=tesla curve (0, 0) (26.8, 0.0920027) (35.7, 0.184004) (41.8, 0.276004) (47.5, 0.368005) (53.4, 0.460005) (60, 0.552006) (67.9, 0.644007) (77.5, 0.736008) (90, 0.828009) (107, 0.920011) (133, 1.01201) (179, 1.10402) (284, 1.19603) (642, 1.28806) (1810, 1.38018) (4030, 1.47241) (7290, 1.56473) (11700, 1.65718)} conductivity=2000000 core_loss_type="Electrical Steel" core_loss_kh=234.541 core_loss_kc=0.368582 mass_density=7242.24
  NdFe30: permittivity=1 permeability=1.044573 conductivity=625000 magnetic_coercivity{Magnitude=-838000A_per_meter DirComp1=1 DirComp2=0 DirComp3=0} lande_g_factor=2 mass_density=7550
  steel_1008: permeability{BType=normal HUnit=A_per_meter BUnit=tesla curve (0, 0) (159.2, 0.2402) (318.3, 0.8654) (477.5, 1.1106) (636.6, 1.2458) (795.8, 1.331) (1591.5, 1.5) (3183.1, 1.6) (4774.6, 1.683) (6366.2, 1.741) (7957.7, 1.78) (15915.5, 1.905) (31831, 2.025) (47746.5, 2.085) (63662, 2.13) (79577.5, 2.165) (159155, 2.28) (318310, 2.485) (397887, 2.5851)} conductivity=2000000 mass_density=7872
  m250-35a_3DSF0.920: permeability{BType=normal HUnit=A_per_meter BUnit=tesla curve (0, 0) (26.8, 0.1) (35.7, 0.2) (41.8, 0.3) (47.5, 0.4) (53.4, 0.5) (60, 0.6) (67.9, 0.7) (77.5, 0.8) (90, 0.9) (107, 1) (133, 1.1) (179, 1.2) (284, 1.3) (642, 1.4) (1810, 1.5) (4030, 1.6) (7290, 1.7) (11700, 1.8) (55800, 2.8)} conductivity=2000000 core_loss_type="Electrical Steel" core_loss_kh=215.778 core_loss_kc=0.339096 mass_density=7872 stacking_type=Lamination stacking_factor=0.92 stacking_direction=V(3)
  steel_1010_3DSF0.950: permeability{BType=normal HUnit=A_per_meter BUnit=tesla curve (0, 0) (238.7, 0.2003) (318.3, 0.3204) (358.1, 0.40045) (437.7, 0.50055) (477.5, 0.5606) (636.6, 0.7908) (795.8, 0.931) (1114.1, 1.1014) (1273.2, 1.2016) (1591.5, 1.302) (2228.2, 1.4028) (3183.1, 1.524) (4774.6, 1.626) (6366.2, 1.698) (7957.7, 1.73) (15915.5, 1.87) (31831, 1.99) (47746.5, 2.04) (63662, 2.07) (79577.5, 2.095) (159155, 2.2) (318310, 2.4) (1909860, 4.4)} conductivity=2000000 mass_density=7872 stacking_type=Lamination stacking_factor=0.95 stacking_direction=V(3)
  NdFe45H_3DSF1.000_N: CoordinateSystemType=Cylindrical permeability=1.0557 conductivity=625000 magnetic_coercivity{Magnitude=-995000A_per_meter DirComp1=1 DirComp2=0 DirComp3=0} mass_density=7400
  NdFe45H_3DSF1.000_S: CoordinateSystemType=Cylindrical permeability=1.0557 conductivity=625000 magnetic_coercivity{Magnitude=-995000A_per_meter DirComp1=-1 DirComp2=0 DirComp3=0} mass_density=7400
  air: permittivity=1.0006 permeability=1.0000004 mass_density=1.1614

design cogging_paralel_slot_shaped_magnet_50mm_50mm_7.5deg_100mm_deep magnet (Maxwell 2D, Transient, XY geometry, model units mm)
options: ModelDepth=100mm Multiplier=fractions
variables:
  fractions = 1
  power = 8000W
  cond = 60
geometry:
  Band [vacuum] = user_primitive(RMxprt/Band, DiaGap=198.5mm, DiaYoke=170mm, Length=0mm, SegAngle=1.6666667deg, Fractions=1, HalfAxial=0, InfoCore=0)
  Shaft [vacuum] = user_primitive(RMxprt/Band, DiaGap=198.5mm, DiaYoke=170mm, Length=0mm, SegAngle=1.6666667deg, Fractions=1, HalfAxial=0, InfoCore=100)
  OuterRegion [vacuum] = user_primitive(RMxprt/Band, DiaGap=198.5mm, DiaYoke=300mm, Length=0mm, SegAngle=1.6666667deg, Fractions=fractions, HalfAxial=0, InfoCore=100)
  Tool = user_primitive(RMxprt/Band, DiaGap=198.5mm, DiaYoke=300mm, Length=0mm, SegAngle=1.6666667deg, Fractions=fractions, HalfAxial=0, InfoCore=1)
  Stator = user_primitive(RMxprt/SlotCore, DiaGap=200mm, DiaYoke=300mm, Length=0mm, Skew=0deg, Slots=24, SlotType=3, Hs0=1.5mm, Hs01=0mm, Hs1=1.5mm, Hs2=31mm, Bs0=7mm, Bs1=13.810552mm, Bs2=21.973007mm, Rs=1.5mm, FilletType=0, HalfSlot=0, SegAngle=15deg, LenRegion=0mm, InfoCore=0)
  Coil_0 [copper] = user_primitive(RMxprt/LapCoil, DiaGap=200mm, DiaYoke=300mm, Length=0mm, Skew=0deg, Slots=24, SlotType=3, Hs0=1.5mm, Hs1=1.5mm, Hs2=31mm, Bs0=7mm, Bs1=13.810552mm, Bs2=21.973007mm, Rs=1.5mm, FilletType=0, Layers=2, CoilPitch=1, EndExt=0mm, SpanExt=0mm, BendAngle=0deg, SegAngle=10deg, LenRegion=0mm, InfoCoil=2)
  Coil_1..Coil_23 [copper] = Coil_0.duplicate_around_axis(axis=Z, angle=15deg, total=24)
  CoilRe_0 [copper] = user_primitive(RMxprt/LapCoil, DiaGap=200mm, DiaYoke=300mm, Length=0mm, Skew=0deg, Slots=24, SlotType=3, Hs0=1.5mm, Hs1=1.5mm, Hs2=31mm, Bs0=7mm, Bs1=13.810552mm, Bs2=21.973007mm, Rs=1.5mm, FilletType=0, Layers=2, CoilPitch=1, EndExt=0mm, SpanExt=0mm, BendAngle=0deg, SegAngle=10deg, LenRegion=0mm, InfoCoil=3)
  CoilRe_0.rotate(axis=Z, angle=-15deg)
  CoilRe_1..CoilRe_23 [copper] = CoilRe_0.duplicate_around_axis(axis=Z, angle=15deg, total=24)
  Rotor = user_primitive(RMxprt/PMCore, DiaGap=197mm, DiaYoke=170mm, Length=0mm, Poles=20, PoleType=1, Embrace=0.82, ThickMag=4.5mm, WidthMag=0mm, Offset=0mm, Bridge=0mm, Rib=0mm, LenRegion=0mm, InfoCore=0)
  Mag_0 [NdFe45H_2DSF1.000_N] = user_primitive(RMxprt/PMCore, DiaGap=197mm, DiaYoke=170mm, Length=0mm, Poles=20, PoleType=1, Embrace=0.82, ThickMag=4.5mm, WidthMag=0mm, Offset=0mm, Bridge=0mm, Rib=0mm, LenRegion=0mm, InfoCore=2)
  Mag_3 = Mag_0.duplicate_around_axis(axis=Z, angle=18deg, total=20)  # copies kept: 3
  Tool_1 = Tool.copy()
  Band.subtract(Tool_1)
  Tool_3 = Tool.copy()
  Shaft.subtract(Tool_3)
  Tool_4 = Tool.copy()
  Stator.subtract(Tool_4)
  Tool_5 = Tool.copy()
  Coil_0.subtract(Tool_5)
  Tool_6 = Tool.copy()
  Coil_1.subtract(Tool_6)
  Tool_7 = Tool.copy()
  Coil_2.subtract(Tool_7)
  Tool_8 = Tool.copy()
  Coil_3.subtract(Tool_8)
  Tool_9 = Tool.copy()
  Coil_4.subtract(Tool_9)
  Tool_10 = Tool.copy()
  Coil_5.subtract(Tool_10)
  Tool_11 = Tool.copy()
  CoilRe_0.subtract(Tool_11)
  Tool_12 = Tool.copy()
  CoilRe_1.subtract(Tool_12)
  Tool_13 = Tool.copy()
  CoilRe_2.subtract(Tool_13)
  Tool_14 = Tool.copy()
  CoilRe_3.subtract(Tool_14)
  Tool_15 = Tool.copy()
  CoilRe_4.subtract(Tool_15)
  Tool_16 = Tool.copy()
  CoilRe_5.subtract(Tool_16)
  Tool_17 = Tool.copy()
  Rotor.subtract(Tool_17)
  Tool_18 = Tool.copy()
  Mag_0.subtract(Tool_18)
  Tool_21 = Tool.copy()
  Tool.delete()
  Mag_3.subtract(Tool_21)
  Polyline1 = polyline((6.59mm, 134.22689mm, 0mm) (6.59mm, 90.959396mm, 0mm))
  Polyline2 = polyline(z=0mm, xy in mm: (6.59, 90.959396) (12.971685, 103.82007) (6.59, 134.22689))
  Polyline1.unite(Polyline2)
  Polyline1.cover_lines()
  Polyline1_1..Polyline1_5 = Polyline1.duplicate_around_axis(axis=Z, angle=-15deg, total=6)
  Stator.subtract(Polyline1, Polyline1_1..Polyline1_5)
  Polyline3 = polyline((134.22689mm, 6.59mm, 0mm) (90.959396mm, 6.59mm, 0mm))
  Polyline4 = polyline(z=0mm, xy in mm: (90.959396, 6.59) (100, 15) (134.22689, 6.59))
  Polyline4.unite(Polyline3)
  Polyline4.cover_lines()
  Polyline4.duplicate_around_axis(axis=Z, angle=15deg, total=6, attached)
  Stator.subtract(Polyline4)
  Polyline5 = polyline(z=0mm, xy in mm: (80.06204, 67.526503) (69.496858, 69.216973) (67.362955, 79.701591), AngularArc from point 0 over 3 centre=(76mm, 76mm, 0mm) angle=-138.8108deg plane=XY)
  Polyline6 = polyline(z=0mm, xy in mm: (67.362955, 79.701591) (57, 70) (70, 57) (80, 61) (80.06204, 67.526503))
  Polyline6.unite(Polyline5)
  Polyline6.cover_lines()
  Polyline6_1, Polyline6_2, Polyline6_3 = Polyline6.duplicate_around_axis(axis=Z, angle=-15deg, total=4)
  Stator.subtract(Polyline6_3)
  Stator.subtract(Polyline6_1, Polyline6_2)
  Polyline6_4, Polyline6_5, Polyline6_6 = Polyline6.duplicate_around_axis(axis=Z, angle=15deg, total=4)
  Stator.subtract(Polyline6, Polyline6_4, Polyline6_5, Polyline6_6)
  Polyline10 = polyline(z=0mm, xy in mm: (69.650018, 69.650018) (73.807258, 64.333907) (76.560451, 58.172446), AngularArc from point 0 over 3 centre=(50mm, 50mm, 0mm) angle=-27.897271deg plane=XY)
  Polyline11 = polyline(z=0mm, xy in mm: (69.650018, 69.650018) (63.471389, 74.305721) (56.248693, 77.077671), AngularArc from point 0 over 3 centre=(50mm, 50mm, 0mm) angle=32.005383deg plane=XY)
  Polyline12 = polyline(z=0mm, xy in mm: (56.248693, 77.077671) (70, 86) (86, 64) (76.560451, 58.172446))
  Polyline12.unite(Polyline11, Polyline10)
  Polyline12.cover_lines()
  Polyline12_1 = Polyline12.duplicate_around_axis(axis=Z, angle=18deg, total=3)  # copies kept: 1
  Polyline12_4 = Polyline12.duplicate_around_axis(axis=Z, angle=-18deg, total=3)  # copies kept: 2
  Polyline12.delete()
  Mag_3.subtract(Polyline12_1)
  Mag_0.subtract(Polyline12_4)
  Polyline17 = polyline(z=0mm, xy in mm: (92.5, 0) (65.407377, 65.407377) (5.6639914e-15, 92.5), AngularArc from point 0 over 3 centre=(0mm, 0mm, 0mm) angle=90deg plane=XY)
  Polyline19 = polyline((0mm, 0mm, 0mm) (74.455202mm, 57.379639mm, 0mm))
  Polyline20 = polyline(z=0mm, xy in mm: (94, 0) (66.468037, 66.468037) (5.75584e-15, 94), AngularArc from point 0 over 3 centre=(0mm, 0mm, 0mm) angle=90deg plane=XY)
  Polyline21 = polyline((0mm, 92.5mm, 0mm) (0mm, 94mm, 0mm))
  Polyline22 = polyline((94mm, 0mm, 0mm) (92.5mm, 0mm, 0mm))
  Polyline22.unite(Polyline20, Polyline17, Polyline21)
  Polyline22.cover_lines()
  Polyline23 = polyline((57.379639mm, 74.455202mm, 0mm) (0mm, 0mm, 0mm))
  Polyline24 = polyline((94mm, 0mm, 0mm) (92.5mm, 0mm, 0mm))
  Polyline26 = polyline(z=0mm, xy in mm: (94, 0) (66.468037, 66.468037) (5.75584e-15, 94), AngularArc from point 0 over 3 centre=(0mm, 0mm, 0mm) angle=90deg plane=XY)
  Polyline25 = polyline(z=0mm, xy in mm: (92.5, 0) (65.407377, 65.407377) (5.6639914e-15, 92.5), AngularArc from point 0 over 3 centre=(0mm, 0mm, 0mm) angle=90deg plane=XY)
  Polyline27 = polyline((0mm, 92.5mm, 0mm) (0mm, 94mm, 0mm))
  Polyline24.unite(Polyline26, Polyline25, Polyline27)
  Polyline24.cover_lines()
  Polyline23.intersect(Polyline24)
  Polyline19.intersect(Polyline22)
  Polyline28 = polyline(z=0mm, xy in mm: (73.267087, 56.464006) (65.407377, 65.407377) (56.464006, 73.267087), AngularArc from point 0 over 3 centre=(0mm, 0mm, 0mm) angle=14.76deg plane=XY)
  Polyline29 = polyline(z=0mm, xy in mm: (74.455202, 57.379639) (66.468037, 66.468037) (57.379639, 74.455202), AngularArc from point 0 over 3 centre=(0mm, 0mm, 0mm) angle=14.76deg plane=XY)
  Polyline29.unite(Polyline19, Polyline28, Polyline23)
  Polyline29.cover_lines()
  Polyline29_1, Polyline29_2 = Polyline29.duplicate_around_axis(axis=Z, angle=18deg, total=3)
  Polyline29_3, Polyline29_4 = Polyline29.duplicate_around_axis(axis=Z, angle=-18deg, total=3)
  Polyline29_5 = Polyline29.copy()
  Polyline29.delete()
  Polyline29_1_1 = Polyline29_1.copy()
  Polyline29_2_1 = Polyline29_2.copy()
  Polyline29_2.delete()
  Polyline29_3_1 = Polyline29_3.copy()
  Polyline29_3.delete()
  Polyline29_4_1 = Polyline29_4.copy()
  Rotor.subtract(Polyline29_5, Polyline29_1_1, Polyline29_2_1, Polyline29_3_1, Polyline29_4_1)
  Mag_3.unite(Polyline29_1)
  Mag_0.unite(Polyline29_4)
  Rotor_Split1 = Rotor.split(plane=YZ, keep=Both)
  Rotor.delete()
  Rotor_Split1_Split1 [steel_1010_2DSF0.950] = Rotor_Split1.split(plane=ZX, keep=Both)
  Rotor_Split1.delete()
  Rotor_Split1_Split1_1, Rotor_Split1_Split1_2, Rotor_Split1_Split1_3 = Rotor_Split1_Split1.duplicate_around_axis(axis=Z, angle=90deg, total=4)
  Rotor_Split1_Split1.unite(Rotor_Split1_Split1_1, Rotor_Split1_Split1_2, Rotor_Split1_Split1_3)
  Mag_1 = Mag_3.duplicate_around_axis(axis=Z, angle=(90/5*3) deg, total=2)
  Mag_3.delete()
  Stator_Split1 = Stator.split(plane=YZ, keep=Both)
  Stator.delete()
  Stator_Split1_Split1 [m250-35a_2DSF0.920] = Stator_Split1.split(plane=ZX, keep=Both)
  Stator_Split1.delete()
  Stator_Split1_Split1_1, Stator_Split1_Split1_2, Stator_Split1_Split1_3 = Stator_Split1_Split1.duplicate_around_axis(axis=Z, angle=90deg, total=4)
  Stator_Split1_Split1.unite(Stator_Split1_Split1_2, Stator_Split1_Split1_1, Stator_Split1_Split1_3)
  Mag_1_1 [NdFe45H_2DSF1.000_S] = Mag_1.duplicate_around_axis(axis=Z, angle=(360/20) deg, total=2)
  Mag_1.delete()
  Mag_0_1..Mag_0_9 = Mag_0.duplicate_around_axis(axis=Z, angle=(360/20*2) deg, total=10)
  Mag_1_1_1..Mag_1_1_9 = Mag_1_1.duplicate_around_axis(axis=Z, angle=(360/20*2) deg, total=10)
  Mag_1_1.unite(Mag_1_1_1..Mag_1_1_6, Mag_1_1_8, Mag_1_1_7, Mag_1_1_9)
  Mag_0.unite(Mag_0_1..Mag_0_9)
motion:
  MotionSetup1: Band Move_Type=Rotate Coordinate_System=Global Axis=Z Is_Positive=true InitPos=0deg Angular_Velocity=600rpm Objects=Band
  Moving1: Moving Objects=[Shaft, Mag_0, Rotor_Split1_Split1, Mag_1_1]
boundaries and excitations:
  VectorPotential2: Vector Potential Edges=OuterRegion.edge(at (0, 150, 0)) Value=0
  PhA_0: Coil Objects=Coil_0 Conductor_number=cond Winding=PhaseA PolarityType=Positive
  PhARe_0: Coil Objects=CoilRe_1 Conductor_number=cond Winding=PhaseA PolarityType=Negative
  PhBRe_2: Coil Objects=Coil_2 Conductor_number=cond Winding=PhaseB PolarityType=Negative
  PhB_2: Coil Objects=CoilRe_3 Conductor_number=cond Winding=PhaseB PolarityType=Positive
  PhCRe_3: Coil Objects=Coil_3 Conductor_number=cond Winding=PhaseC PolarityType=Negative
  PhC_3: Coil Objects=CoilRe_4 Conductor_number=cond Winding=PhaseC PolarityType=Positive
  PhC_4: Coil Objects=Coil_4 Conductor_number=cond Winding=PhaseC PolarityType=Positive
  PhCRe_4: Coil Objects=CoilRe_5 Conductor_number=cond Winding=PhaseC PolarityType=Negative
  PhA_5: Coil Objects=Coil_5 Conductor_number=cond Winding=PhaseA PolarityType=Positive
  PhARe_5: Coil Objects=CoilRe_0 Conductor_number=cond Winding=PhaseA PolarityType=Positive
  CoilRe_2: Coil Objects=CoilRe_2 Conductor_number=cond Winding=PhaseB PolarityType=Negative
  Coil_1: Coil Objects=Coil_1 Conductor_number=cond Winding=PhaseB PolarityType=Positive
  Coil_6: Coil Objects=Coil_6 Conductor_number=cond Winding=PhaseA PolarityType=Negative
  Coil_12: Coil Objects=Coil_12 Conductor_number=cond Winding=PhaseA PolarityType=Positive
  Coil_18: Coil Objects=Coil_18 Conductor_number=cond Winding=PhaseA PolarityType=Negative
  CoilRe_6: Coil Objects=CoilRe_6 Conductor_number=cond Winding=PhaseA PolarityType=Negative
  CoilRe_12: Coil Objects=CoilRe_12 Conductor_number=cond Winding=PhaseA PolarityType=Positive
  CoilRe_18: Coil Objects=CoilRe_18 Conductor_number=cond Winding=PhaseA PolarityType=Negative
  CoilRe_7: Coil Objects=CoilRe_7 Conductor_number=cond Winding=PhaseA PolarityType=Positive
  CoilRe_13: Coil Objects=CoilRe_13 Conductor_number=cond Winding=PhaseA PolarityType=Negative
  CoilRe_19: Coil Objects=CoilRe_19 Conductor_number=cond Winding=PhaseA PolarityType=Positive
  Coil_11: Coil Objects=Coil_11 Conductor_number=cond Winding=PhaseA PolarityType=Negative
  Coil_17: Coil Objects=Coil_17 Conductor_number=cond Winding=PhaseA PolarityType=Positive
  Coil_23: Coil Objects=Coil_23 Conductor_number=cond Winding=PhaseA PolarityType=Negative
  Coil_7: Coil Objects=Coil_7 Conductor_number=cond Winding=PhaseB PolarityType=Negative
  Coil_13: Coil Objects=Coil_13 Conductor_number=cond Winding=PhaseB PolarityType=Positive
  Coil_19: Coil Objects=Coil_19 Conductor_number=cond Winding=PhaseB PolarityType=Negative
  CoilRe_8: Coil Objects=CoilRe_8 Conductor_number=cond Winding=PhaseB PolarityType=Positive
  CoilRe_14: Coil Objects=CoilRe_14 Conductor_number=cond Winding=PhaseB PolarityType=Negative
  CoilRe_20: Coil Objects=CoilRe_20 Conductor_number=cond Winding=PhaseB PolarityType=Positive
  Coil_8: Coil Objects=Coil_8 Conductor_number=cond Winding=PhaseB PolarityType=Positive
  Coil_14: Coil Objects=Coil_14 Conductor_number=cond Winding=PhaseB PolarityType=Negative
  Coil_20: Coil Objects=Coil_20 Conductor_number=cond Winding=PhaseB PolarityType=Positive
  CoilRe_9: Coil Objects=CoilRe_9 Conductor_number=cond Winding=PhaseB PolarityType=Negative
  CoilRe_15: Coil Objects=CoilRe_15 Conductor_number=cond Winding=PhaseB PolarityType=Positive
  CoilRe_21: Coil Objects=CoilRe_21 Conductor_number=cond Winding=PhaseB PolarityType=Negative
  Coil_9: Coil Objects=Coil_9 Conductor_number=cond Winding=PhaseC PolarityType=Positive
  Coil_15: Coil Objects=Coil_15 Conductor_number=cond Winding=PhaseC PolarityType=Negative
  Coil_21: Coil Objects=Coil_21 Conductor_number=cond Winding=PhaseC PolarityType=Positive
  CoilRe_10: Coil Objects=CoilRe_10 Conductor_number=cond Winding=PhaseC PolarityType=Negative
  CoilRe_16: Coil Objects=CoilRe_16 Conductor_number=cond Winding=PhaseC PolarityType=Positive
  CoilRe_22: Coil Objects=CoilRe_22 Conductor_number=cond Winding=PhaseC PolarityType=Negative
  Coil_10: Coil Objects=Coil_10 Conductor_number=cond Winding=PhaseC PolarityType=Negative
  Coil_16: Coil Objects=Coil_16 Conductor_number=cond Winding=PhaseC PolarityType=Positive
  Coil_22: Coil Objects=Coil_22 Conductor_number=cond Winding=PhaseC PolarityType=Negative
  CoilRe_11: Coil Objects=CoilRe_11 Conductor_number=cond Winding=PhaseC PolarityType=Positive
  CoilRe_17: Coil Objects=CoilRe_17 Conductor_number=cond Winding=PhaseC PolarityType=Negative
  CoilRe_23: Coil Objects=CoilRe_23 Conductor_number=cond Winding=PhaseC PolarityType=Positive
  PhaseA: Winding Group Type=Voltage IsSolid=false Current=0A Resistance=0.364272ohm Inductance=2.42275e-05H Voltage="228.619 * sin(2*pi*100*time+19.9162*pi/180)" ParallelBranchesNum=2
  PhaseB: Winding Group Type=Voltage IsSolid=false Current=0A Resistance=0.364272ohm Inductance=2.42275e-05H Voltage="228.619 * sin(2*pi*100*time+19.9162*pi/180-2*pi/3)" ParallelBranchesNum=2
  PhaseC: Winding Group Type=Voltage IsSolid=false Current=0A Resistance=0.364272ohm Inductance=2.42275e-05H Voltage="228.619 * sin(2*pi*100*time+19.9162*pi/180-4*pi/3)" ParallelBranchesNum=2
  Y connection: PhaseA, PhaseB, PhaseC
mesh:
  Length_Coil: LengthBased RefineInside Objects=[Coil_0..Coil_21, Coil_23, Coil_22, CoilRe_0..CoilRe_7, CoilRe_23, CoilRe_22, CoilRe_21, CoilRe_20, CoilRe_19, CoilRe_18, CoilRe_17, CoilRe_16, CoilRe_8..CoilRe_13, CoilRe_15, CoilRe_14] NumMaxElem=1000 MaxLength=8.94589mm
  Length_Mag: LengthBased RefineInside Objects=[Mag_0, Mag_1_1] NumMaxElem=1000 MaxLength=1mm
  SurfApprox_Mag: SurfApproxBased Objects=[Mag_0, Mag_1_1] CurvedSurfaceApproxChoice=UseSlider SliderMeshSettings=7
  SurfApprox_Main: SurfApproxBased Objects=[Band, Shaft, OuterRegion, Coil_0..Coil_23, CoilRe_0..CoilRe_23, Mag_0, Rotor_Split1_Split1, Stator_Split1_Split1, Mag_1_1] CurvedSurfaceApproxChoice=UseSlider SliderMeshSettings=9
  Length_Main: LengthBased RefineInside Objects=[Band, Shaft, OuterRegion, Coil_0..Coil_23, CoilRe_0..CoilRe_23, Mag_0, Rotor_Split1_Split1, Stator_Split1_Split1, Mag_1_1] NumMaxElem=1000 MaxLength=8mm
  initial mesh: MeshMethod=AnsoftTAU
setups:
  Setup1: Transient NonlinearSolverResidual=0.0001 StopTime=0.03s TimeStep=0.0002s FastReachSteadyState FrequencyOfAddedVoltageSource=100Hz SweepSetupType=LinearStep StartValue=0ns StopValue=0.015s StepSize=0.0001s InitialTimeStep=0.002s MinTimeStep=0.001s MaxTimeStep=0.003s TimeStepErrTolerance=0.0001
field plots:
  Mag_B1: B over Band, Shaft, OuterRegion, Coil_0..Coil_5, CoilRe_0..CoilRe_5, Mag_0 on Setup1 : Transient at Time=-1
reports:
  Torque: Moving1.Torque vs Time on Setup1 : Transient
  Currents: Current(PhaseA), Current(PhaseB), Current(PhaseC) vs Time on Setup1 : Transient; markers m1 at 10.8ms
  Induced Voltages: InducedVoltage(PhaseA), InducedVoltage(PhaseB), InducedVoltage(PhaseC), InducedVoltage(failure) vs Time on Setup1 : Transient; markers m1 at 3.6993865ms, m2 at 2ms, m3 at 66ms, m4 at 87000000ns
  Flux Linkages: FluxLinkage(PhaseA), FluxLinkage(PhaseB), FluxLinkage(PhaseC), FluxLinkage(failure) vs Time on Setup1 : Transient
  Voltages: InputVoltage(PhaseA), InputVoltage(PhaseB), InputVoltage(PhaseC) vs Time on Setup1 : Transient
  Powers: InputVoltage(PhaseA)*Current(PhaseA) + InputVoltage(PhaseB)*Current(PhaseB) + InputVoltage(PhaseC)*Current(PhaseC), Moving1.Speed*Moving1.Torque vs Time on Setup1 : Transient
  XY Plot 1: CoreLoss vs Time on Setup1 : Transient
  XY Plot 2: StrandedLossR vs Time on Setup1 : Transient
  XY Plot 3: InputVoltage(PhaseA), InducedVoltage(PhaseA) vs Time on Setup1 : Transient
  Data Table 1: mean(Moving1.Torque) vs fractions on Setup1 : Transient
  Phase shift: InducedVoltage(PhaseA), InputVoltage(PhaseA), Current(PhaseA) vs Time on Setup1 : Transient; markers m1 at 13600000ns, m2 at 12.8ms
  PhB-Current Voltage: InducedVoltage(PhaseB), InputVoltage(PhaseB), Current(PhaseB) vs Time on Setup1 : Transient
  XY Plot 6: InducedVoltage(PhaseC), InputVoltage(PhaseC), Current(PhaseC) vs Time on Setup1 : Transient
  XY Plot 7: InducedVoltage(PhaseA)*Current(PhaseA) vs Time on Setup1 : Transient

design 240mm_dia (Maxwell 2D, Transient, XY geometry, model units mm)
options: ModelDepth=180mm Multiplier=fractions
variables:
  fractions = 4
  power = 8500W
geometry:
  Band [vacuum] = user_primitive(RMxprt/Band, DiaGap=148.5mm, DiaYoke=120mm, Length=0mm, SegAngle=1.875deg, Fractions=1, HalfAxial=0, InfoCore=0)
  Shaft [vacuum] = user_primitive(RMxprt/Band, DiaGap=148.5mm, DiaYoke=120mm, Length=0mm, SegAngle=1.875deg, Fractions=1, HalfAxial=0, InfoCore=100)
  OuterRegion [vacuum] = user_primitive(RMxprt/Band, DiaGap=148.5mm, DiaYoke=240mm, Length=0mm, SegAngle=1.875deg, Fractions=fractions, HalfAxial=0, InfoCore=100)
  Tool = user_primitive(RMxprt/Band, DiaGap=148.5mm, DiaYoke=240mm, Length=0mm, SegAngle=1.875deg, Fractions=fractions, HalfAxial=0, InfoCore=1)
  Stator [m250-35a_2DSF0.920] = user_primitive(RMxprt/SlotCore, DiaGap=150mm, DiaYoke=240mm, Length=0mm, Skew=0deg, Slots=24, SlotType=4, Hs0=0.5mm, Hs01=0mm, Hs1=0mm, Hs2=31mm, Bs0=10.5mm, Bs1=11mm, Bs2=17.5mm, Rs=3mm, FilletType=0, HalfSlot=0, SegAngle=15deg, LenRegion=0mm, InfoCore=0)
  Coil_0 [copper] = user_primitive(RMxprt/LapCoil, DiaGap=150mm, DiaYoke=240mm, Length=0mm, Skew=0deg, Slots=24, SlotType=4, Hs0=0.5mm, Hs1=0mm, Hs2=31mm, Bs0=10.5mm, Bs1=11mm, Bs2=17.5mm, Rs=3mm, FilletType=0, Layers=2, CoilPitch=1, EndExt=0mm, SpanExt=0mm, BendAngle=0deg, SegAngle=10deg, LenRegion=0mm, InfoCoil=2)
  Coil_1..Coil_5 [copper], Coil_6..Coil_23 = Coil_0.duplicate_around_axis(axis=Z, angle=15deg, total=24)
  Coil_0.unite(Coil_6, Coil_12, Coil_18)
  Coil_1.unite(Coil_7, Coil_13, Coil_19)
  Coil_2.unite(Coil_8, Coil_14, Coil_20)
  Coil_3.unite(Coil_9, Coil_15, Coil_21)
  Coil_4.unite(Coil_10, Coil_16, Coil_22)
  Coil_5.unite(Coil_11, Coil_17, Coil_23)
  CoilRe_0 [copper] = user_primitive(RMxprt/LapCoil, DiaGap=150mm, DiaYoke=240mm, Length=0mm, Skew=0deg, Slots=24, SlotType=4, Hs0=0.5mm, Hs1=0mm, Hs2=31mm, Bs0=10.5mm, Bs1=11mm, Bs2=17.5mm, Rs=3mm, FilletType=0, Layers=2, CoilPitch=1, EndExt=0mm, SpanExt=0mm, BendAngle=0deg, SegAngle=10deg, LenRegion=0mm, InfoCoil=3)
  CoilRe_0.rotate(axis=Z, angle=-15deg)
  CoilRe_1..CoilRe_5 [copper], CoilRe_6..CoilRe_23 = CoilRe_0.duplicate_around_axis(axis=Z, angle=15deg, total=24)
  CoilRe_0.unite(CoilRe_6, CoilRe_12, CoilRe_18)
  CoilRe_1.unite(CoilRe_7, CoilRe_13, CoilRe_19)
  CoilRe_2.unite(CoilRe_8, CoilRe_14, CoilRe_20)
  CoilRe_3.unite(CoilRe_9, CoilRe_15, CoilRe_21)
  CoilRe_4.unite(CoilRe_10, CoilRe_16, CoilRe_22)
  CoilRe_5.unite(CoilRe_11, CoilRe_17, CoilRe_23)
  Rotor [steel_1010_2DSF0.950] = user_primitive(RMxprt/PMCore, DiaGap=147mm, DiaYoke=120mm, Length=0mm, Poles=20, PoleType=1, Embrace=0.82, ThickMag=4.5mm, WidthMag=0mm, Offset=0mm, Bridge=0mm, Rib=0mm, LenRegion=0mm, InfoCore=0)
  Mag_0 [NdFe45H_2DSF1.000_N] = user_primitive(RMxprt/PMCore, DiaGap=147mm, DiaYoke=120mm, Length=0mm, Poles=20, PoleType=1, Embrace=0.82, ThickMag=4.5mm, WidthMag=0mm, Offset=0mm, Bridge=0mm, Rib=0mm, LenRegion=0mm, InfoCore=2)
  Mag_1 [NdFe45H_2DSF1.000_S], Mag_2 [NdFe45H_2DSF1.000_N], Mag_3 [NdFe45H_2DSF1.000_S], Mag_4 [NdFe45H_2DSF1.000_N], Mag_5..Mag_19 = Mag_0.duplicate_around_axis(axis=Z, angle=18deg, total=20)
  Mag_0.unite(Mag_5, Mag_10, Mag_15)
  Mag_1.unite(Mag_6, Mag_11, Mag_16)
  Mag_2.unite(Mag_7, Mag_12, Mag_17)
  Mag_3.unite(Mag_8, Mag_13, Mag_18)
  Mag_4.unite(Mag_9, Mag_14, Mag_19)
  InnerRegion [vacuum] = user_primitive(RMxprt/PMCore, DiaGap=147mm, DiaYoke=120mm, Length=0mm, Poles=20, PoleType=1, Embrace=0.82, ThickMag=4.5mm, WidthMag=0mm, Offset=0mm, Bridge=0mm, Rib=0mm, LenRegion=0mm, InfoCore=100)
  Tool_1 = Tool.copy()
  Band.subtract(Tool_1)
  Tool_2 = Tool.copy()
  InnerRegion.subtract(Tool_2)
  Tool_3 = Tool.copy()
  Shaft.subtract(Tool_3)
  Tool_4 = Tool.copy()
  Stator.subtract(Tool_4)
  Tool_5 = Tool.copy()
  Coil_0.subtract(Tool_5)
  Tool_6 = Tool.copy()
  Coil_1.subtract(Tool_6)
  Tool_7 = Tool.copy()
  Coil_2.subtract(Tool_7)
  Tool_8 = Tool.copy()
  Coil_3.subtract(Tool_8)
  Tool_9 = Tool.copy()
  Coil_4.subtract(Tool_9)
  Tool_10 = Tool.copy()
  Coil_5.subtract(Tool_10)
  Tool_11 = Tool.copy()
  CoilRe_0.subtract(Tool_11)
  Tool_12 = Tool.copy()
  CoilRe_1.subtract(Tool_12)
  Tool_13 = Tool.copy()
  CoilRe_2.subtract(Tool_13)
  Tool_14 = Tool.copy()
  CoilRe_3.subtract(Tool_14)
  Tool_15 = Tool.copy()
  CoilRe_4.subtract(Tool_15)
  Tool_16 = Tool.copy()
  CoilRe_5.subtract(Tool_16)
  Tool_17 = Tool.copy()
  Rotor.subtract(Tool_17)
  Tool_18 = Tool.copy()
  Mag_0.subtract(Tool_18)
  Tool_19 = Tool.copy()
  Mag_1.subtract(Tool_19)
  Tool_20 = Tool.copy()
  Mag_2.subtract(Tool_20)
  Tool_21 = Tool.copy()
  Mag_3.subtract(Tool_21)
  Mag_4.subtract(Tool)
motion:
  MotionSetup1: Band Move_Type=Rotate Coordinate_System=Global Axis=Z Is_Positive=true InitPos=7.5deg Angular_Velocity=600rpm Objects=Band
  Moving1: Moving Objects=[Shaft, Rotor, Mag_0..Mag_4, InnerRegion]
boundaries and excitations:
  VectorPotential1: Vector Potential Edges=OuterRegion.edge(at (84.8528, 84.8528, 0)) Value=0
  Master1: Master Edges=OuterRegion.edge(at (60, 0, 0))
  Slave1: Slave Edges=OuterRegion.edge(at (0, 60, 0)) ReverseU master=Master1 SameAsMaster=false
  PhA_0: Coil Objects=Coil_0 Conductor_number=40 Winding=PhaseA PolarityType=Positive
  PhARe_0: Coil Objects=CoilRe_1 Conductor_number=40 Winding=PhaseA PolarityType=Negative
  PhB_1: Coil Objects=Coil_1 Conductor_number=40 Winding=PhaseB PolarityType=Positive
  PhBRe_1: Coil Objects=CoilRe_2 Conductor_number=40 Winding=PhaseB PolarityType=Negative
  PhBRe_2: Coil Objects=Coil_2 Conductor_number=40 Winding=PhaseB PolarityType=Negative
  PhB_2: Coil Objects=CoilRe_3 Conductor_number=40 Winding=PhaseB PolarityType=Positive
  PhCRe_3: Coil Objects=Coil_3 Conductor_number=40 Winding=PhaseC PolarityType=Negative
  PhC_3: Coil Objects=CoilRe_4 Conductor_number=40 Winding=PhaseC PolarityType=Positive
  PhC_4: Coil Objects=Coil_4 Conductor_number=40 Winding=PhaseC PolarityType=Positive
  PhCRe_4: Coil Objects=CoilRe_5 Conductor_number=40 Winding=PhaseC PolarityType=Negative
  PhA_5: Coil Objects=Coil_5 Conductor_number=40 Winding=PhaseA PolarityType=Positive
  PhA_23: Coil Objects=CoilRe_0 Conductor_number=40 Winding=PhaseA PolarityType=Positive
  PhaseA: Winding Group Type=Voltage IsSolid=false Current=0A Resistance=0.330618ohm Inductance=5.19871e-06H Voltage="244.949 * sin(2*pi*100*time+15.68*pi/180)" ParallelBranchesNum=2
  PhaseB: Winding Group Type=Voltage IsSolid=false Current=0A Resistance=0.330618ohm Inductance=5.19871e-06H Voltage="244.949 * sin(2*pi*100*time+15.68*pi/180-2*pi/3)" ParallelBranchesNum=2
  PhaseC: Winding Group Type=Voltage IsSolid=false Current=0A Resistance=0.330618ohm Inductance=5.19871e-06H Voltage="244.949 * sin(2*pi*100*time+15.68*pi/180-4*pi/3)" ParallelBranchesNum=2
  Y connection: PhaseA, PhaseB, PhaseC
mesh:
  Length_Coil: LengthBased RefineInside Objects=[Coil_0..Coil_5, CoilRe_0..CoilRe_5] MaxLength=7.125mm
  Length_Mag: LengthBased RefineInside Objects=[Mag_0..Mag_4] MaxLength=2.25mm
  SurfApprox_Mag: SurfApproxBased Objects=[Mag_0..Mag_4] CurvedSurfaceApproxChoice=ManualSettings SurfDev=0.0735mm NormalDev=15deg
  SurfApprox_Main: SurfApproxBased Objects=[Stator, Rotor, Band, OuterRegion, InnerRegion, Shaft] CurvedSurfaceApproxChoice=ManualSettings SurfDev=0.12mm NormalDev=15deg
  Length_Main: LengthBased RefineInside Objects=[Stator, Rotor, Band, OuterRegion, InnerRegion, Shaft] MaxLength=9.3mm
  initial mesh: MeshMethod=AnsoftTAU
setups:
  Setup1: Transient NonlinearSolverResidual=0.0001 StopTime=0.08s TimeStep=0.0001s FastReachSteadyState FrequencyOfAddedVoltageSource=100Hz SweepSetupType=LinearStep StartValue=0ns StopValue=80000000ns StepSize=10000000ns InitialTimeStep=0.002s MinTimeStep=0.001s MaxTimeStep=0.003s TimeStepErrTolerance=0.0001
field plots:
  Mag_B1: B over Band, Shaft, OuterRegion, Stator, Coil_0..Coil_5, CoilRe_0..CoilRe_5, Rotor, Mag_0..Mag_4, InnerRegion on Setup1 : Transient at Time=0.07s
  Flux_Lines1: A over Band, Shaft, OuterRegion, Stator, Coil_0..Coil_5, CoilRe_0..CoilRe_5, Rotor, Mag_0..Mag_4, InnerRegion on Setup1 : Transient at Time=0s
reports:
  Torque: Moving1.Torque vs Time on Setup1 : Transient
  Currents: Current(PhaseA), Current(PhaseB), Current(PhaseC) vs Time on Setup1 : Transient
  Induced Voltages: InducedVoltage(PhaseA), InducedVoltage(PhaseB), InducedVoltage(PhaseC) vs Time on Setup1 : Transient
  Flux Linkages: FluxLinkage(PhaseA), FluxLinkage(PhaseB), FluxLinkage(PhaseC) vs Time on Setup1 : Transient
  Voltages: InputVoltage(PhaseA), InputVoltage(PhaseB), InputVoltage(PhaseC) vs Time on Setup1 : Transient
  Powers: InputVoltage(PhaseA)*Current(PhaseA) + InputVoltage(PhaseB)*Current(PhaseB) + InputVoltage(PhaseC)*Current(PhaseC), Moving1.Speed*Moving1.Torque vs Time on Setup1 : Transient

design pmsg-1 (RMxprt, Adjust-Speed Synchronous Machine, model units mm)
variables:
  power = 8500W
  speed = 600rpm
machine:
  Machine: FrictionLoss=12W WindLoss=0W ReferenceSpeed=600rpm NumberOfPoles=20 RotorPosition=true ControlType=3 CircuitType=Y3
  Stator: SkewWidth=0 NumberOfSlots=24 LaminationSectors=0 PressBoardThickness=0mm OuterDiameter=240mm InnerDiameter=150mm Length=$length StackingFactor=0.92 SteelType=m250-35a SlotType=4
  Rotor: OuterDiameter=147mm InnerDiameter=120mm Length=$length SteelType=steel_1010 PoleType=1 StackingFactor=0.95
  Shaft:
  Stator Slot: Hs0=0.5mm Hs1=0mm Hs2=31mm Bs0=10.5mm Bs1=11mm Bs2=17.5mm Rs=3mm ToothWidth=13.18mm
  Stator Winding: WindingType=Whole-Coiled WindingLayers=2 ParallelBranches=2 ConductorsPerSlot=80 CoilPitch=1 EndAdjustment=0mm BaseInnerRadius=0mm TipInnerDiameter=0mm EndClearance=0mm CoilWrap=0mm SlotLiner=0.3mm WedgeThickness=0mm LayerInsulation=0mm BottomInsulation=0mm LimitedFillFactor=0.75 WdgNumberofPriodicMultipler=1 NumberOfStrands=1 WireWrap=0mm InterturnInsulation=0mm WireDiameter=1.628mm WireWidth=0mm WireThickness=0mm Gauge=14
  Rotor Pole: Embrace=0.82 Offset=0mm ShaftDiameter=0mm Bridge=0mm Rib=0mm MagnetThickness=4.5mm MagnetWidth=0mm MagnetType=NdFe45H
setups:
  Setup2: ASSM Motor RatedOutputPower=8500W RatedVoltage=300V RatedSpeed=600rpm OperatingTemperature=75cel LoadType=ConstPower RatedPowerFactor=0.75
optimetrics:
  ParametricSetup2: Parametric Sim._Setups=[Setup2]
    sweep $length: 180mm
    sweep $conductor: 80
