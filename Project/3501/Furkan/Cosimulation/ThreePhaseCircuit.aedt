# Ansys Electronics Desktop project, version 2018.2

design Circuit1 (Circuit)
options: SParamCircuitDef IntegrationMethod=FFT
components:
  S7 = Q3DModel3()
  U9 = GS66508B_L1V3()
  U1 = GS66508B_L1V3()
  U2 = GS66508B_L1V3()
  U3 = GS66508B_L1V3()
  U4 = GS66508B_L1V3()
  U5 = GS66508B_L1V3()
  V35 = V_DC(DC=270V)
  R44 = RES_(R=0.0211)
  L45 = IND_(L=1.9e-08)
  C47 = CAP_(C=5uF)
  C1 = CAP_(C=5uF)
  L1 = IND_(L=1.9e-08)
  R1 = RES_(R=0.0211)
  C2 = CAP_(C=5uF)
  L2 = IND_(L=1.9e-08)
  R2 = RES_(R=0.0211)
  R59 = RES_(R=10)
  R60 = RES_(R=2)
  D61 = DIODE_Level5(AREA=2)
  Z63 = SIN(F=50Hz Amplitude=0.95V)
  Z1 = SIN(F=50Hz Amplitude=0.95V Phase=120deg)
  Z2 = SIN(F=50Hz Amplitude=0.95V Phase=240deg)
  Z68 = TRIANGLE(PERIOD="(1/50000) s")
  E69 = VCVS_Poly()
  U71 = Model()
  U72 = Model()
nets:
  net_1: S7.6, C1.0
  net_10: S7.21, U1.1
  net_11: S7.3, U1.2
  net_12: U3.1, S7.15
  net_13: U3.2, S7.1
  net_14: S7.22, U2.1
  net_15: S7.5, U2.2
  net_16: S7.16, U5.1
  net_17: S7.2, U5.2
  net_18: U4.1, S7.23
  net_19: U4.2, S7.7
  net_2: S7.14, L1.1
  net_20: S7.17, S7.18, S7.19, S7.20, V35.0
  net_21: S7.8, S7.9, S7.10, S7.11, V35.1
  net_22: R44.0, C47.1
  net_23: R44.1, L45.0
  net_24: S7.12, L45.1
  net_25: S7.4, C47.0
  net_26: R2.0, C2.1
  net_27: D61.0, R60.1
  net_28: D61.1, R59.1
  net_29: U9.0, R60.0, R59.0
  net_3: L1.0, R1.1
  net_4: C1.1, R1.0
  net_5: S7.24, C2.0
  net_6: S7.25, L2.1
  net_7: R2.1, L2.0
  net_8: S7.13, U9.1
  net_9: S7.0, U9.2

design TwinBuilder1 (Twin Builder)
variables:
  R1 = 10
components:
  SINE1 = SINE(AMPL=0.95*0.5 PERIO=0 TPERIO=Tend+1 OFF=1)
  TRIANG1 = TRIANG(AMPL=0.5 FREQ=50kHz OFF=1 PERIO=0 TPERIO=Tend+1)
  SINE2 = SINE(AMPL=0.95*0.5 PERIO=0 TPERIO=Tend+1 PHASE=120deg OFF=1)
  SINE3 = SINE(AMPL=0.95*0.5 PERIO=0 TPERIO=Tend+1 PHASE=240deg OFF=1)
  POS = CONST(CONST=6)
  NEG = CONST(CONST=-3)
  SUM2 = SUM(Invert[0]=false Invert[1]=true Invert[2]=false Invert[3]=false Invert[4]=false Invert[5]=false Invert[6]=false Invert[7]=false INPUT[0]=SINE1.VAL INPUT[1]=TRIANG1.VAL)
  COMP1 = COMP(INPUT=SUM2.VAL VAL1=1 VAL2=-1)
  SUM1 = SUM(Invert[0]=false Invert[1]=true Invert[2]=false Invert[3]=false Invert[4]=false Invert[5]=false Invert[6]=false Invert[7]=false INPUT[0]=SINE2.VAL INPUT[1]=TRIANG1.VAL)
  COMP2 = COMP(INPUT=SUM1.VAL VAL1=1 VAL2=-1)
  SUM3 = SUM(Invert[0]=false Invert[1]=true Invert[2]=false Invert[3]=false Invert[4]=false Invert[5]=false Invert[6]=false Invert[7]=false INPUT[0]=SINE3.VAL INPUT[1]=TRIANG1.VAL)
  COMP3 = COMP(INPUT=SUM3.VAL VAL1=1 VAL2=-1)
  DEADTIME2 = DEADTIME(G_R1=InOut0 G_R2=InOut1 G_S1=InOut2 G_S2=InOut3 G_T1=InOut4 G_T2=InOut5 Z_R=COMP1.VAL Z_S=COMP2.VAL Z_T=COMP3.VAL T_DEAD=1e-07s)
  SW21_1 = SW21(CTRL=InOut0 INPUT_1=POS.VAL INPUT_2=NEG.VAL)
  SW21_2 = SW21(CTRL=InOut1 INPUT_1=POS.VAL INPUT_2=NEG.VAL)
  SW21_3 = SW21(CTRL=InOut2 INPUT_1=POS.VAL INPUT_2=NEG.VAL)
  SW21_4 = SW21(CTRL=InOut3 INPUT_1=POS.VAL INPUT_2=NEG.VAL)
  SW21_5 = SW21(CTRL=InOut4 INPUT_1=POS.VAL INPUT_2=NEG.VAL)
  SW21_6 = SW21(CTRL=InOut5 INPUT_1=POS.VAL INPUT_2=NEG.VAL)
  SubSheet1 = CapacitorModel()
  SubSheet2 = CapacitorModel()
  SubSheet3 = CapacitorModel()
  R4 = R(R=R1)
  C4 = C(C=C1)
nets:
  ABotGD: SW21_2.VAL
  ATopGD: SW21_1.VAL
  BBotGD: SW21_4.VAL
  BTopGD: SW21_3.VAL
  CBotGD: SW21_6.VAL
  CTopGD: SW21_5.VAL
  net_10: DEADTIME2.Z_R, COMP1.VAL
  net_11: DEADTIME2.Z_T, COMP3.VAL
  net_19: SW21_6.INPUT_1, POS.VAL, SW21_1.INPUT_1, SW21_3.INPUT_1, SW21_2.INPUT_1, SW21_4.INPUT_1, SW21_5.INPUT_1
  net_2: SINE1.VAL, SUM2.INPUT[0]
  net_20: SW21_6.INPUT_2, NEG.VAL, SW21_1.INPUT_2, SW21_3.INPUT_2, SW21_2.INPUT_2, SW21_4.INPUT_2, SW21_5.INPUT_2
  net_21: DEADTIME2.G_R1, SW21_1.CTRL
  net_22: DEADTIME2.G_R2, SW21_2.CTRL
  net_3: SUM1.INPUT[0], SINE2.VAL
  net_30: DEADTIME2.G_S1, SW21_3.CTRL
  net_31: DEADTIME2.G_S2, SW21_4.CTRL
  net_32: DEADTIME2.G_T1, SW21_5.CTRL
  net_33: DEADTIME2.G_T2, SW21_6.CTRL
  net_4: SUM3.INPUT[0], SINE3.VAL
  net_5: SUM3.INPUT[1], TRIANG1.VAL, SUM2.INPUT[1], SUM1.INPUT[1]
  net_6: SUM2.VAL, COMP1.INPUT
  net_7: SUM1.VAL, COMP2.INPUT
  net_8: SUM3.VAL, COMP3.INPUT
  net_9: DEADTIME2.Z_S, COMP2.VAL
setups:
  TR: TransientData(20ms, 0.1us, 1ms, false, "")
reports:
  XY Plot 1: SW21_1.VAL, SW21_2.VAL, SW21_3.VAL, SW21_5.VAL vs Time on TR : TR
  XY Plot 2: SINE1.VAL, SINE2.VAL, SINE3.VAL, TRIANG1.VAL vs Time on TR : TR

design CapacitorModel (Twin Builder)
components:
  L1 = L(I=0A L=19nH V=0V)
  R1 = R(I=0A R=21.1mOhm V=0V)
  C1 = C(UseInitialConditions=true V0=270V C=5e-06farad)
  port Cap+
  port Cap-
nets:
  Cap+: C1.0
  Cap-: L1.1
  net_34: L1.0, R1.1
  net_35: R1.0, C1.1
setups:
  TR: TransientData(20ms, 0.1us, 1ms, false, "")
